* MPX 出力段 rev.E : LPF 定数見直し ＋ 非反転2段利得段
.model QX NPN(IS=2.64e-14 BF=321 VAF=100 IKF=0.3 ISE=20f NE=1.5 BR=4 VAR=10
+ IKR=0.05 ISC=10f NC=1.5 RE=0.3 RC=0.6 RB=4.5 CJE=9.469p VJE=0.75 MJE=0.33
+ CJC=7.834p VJC=0.75 MJC=0.33 TF=0.409n TR=10n EG=1.11 XTI=3)
V1 VCC 0 DC 5
IOB OB 0 DC 1.143m AC 1 SIN(1.143m {IA} {FRQ})
RLB VCC OB 1.5k
CLB OB 0 {CX}
RF1 OB LP 1k
CF1 LP 0 {CX}
Q16 VCC LP AFE QX
RE16 AFE 0 4.7k
C1 AFE B17 1u
R1A VCC B17 100k
R1B B17 0 51k
Q17 C17 B17 E17 QX
R1E E17 0 {RE}
R1C VCC C17 2.2k
C2 C17 B18 1u
R2A VCC B18 100k
R2B B18 0 51k
Q18 C18 B18 E18 QX
R2E E18 0 {RE}
R2C VCC C18 2.2k
COUT C18 MPX 10u
RVR MPX 0 47k
.end
