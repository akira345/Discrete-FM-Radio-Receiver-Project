* 検波ブロック単体（S4A/S4B を外部差動源で駆動）
.model QX NPN(IS=2.64e-14 BF=321 VAF=100 IKF=0.3 ISE=20f NE=1.5 BR=4 VAR=10
+ IKR=0.05 ISC=10f NC=1.5 RE=0.3 RC=0.6 RB=4.5 CJE=9.469p VJE=0.75 MJE=0.33
+ CJC=7.834p VJC=0.75 MJC=0.33 TF=0.409n TR=10n EG=1.11 XTI=3)
.model JF NJF(VTO=-1.2 BETA=8m LAMBDA=2m RD=5 RS=5 CGS=4p CGD=2p)
V1   VCC 0 DC 5
C0   VCC 0 10u
RU1  VCC VBU 10k
RU2  VBU 0   9.1k
CU   VBU 0   0.1u
RV1  VCC VBL 10k
RV2  VBL 0   4.7k
CV   VBL 0   0.1u
* --- 外部差動ドライブ（AD3 W1 / W2）---
VA   S4A 0 DC 0 SIN(0 {AMP} {FRQ} 0 0 0)
VB   S4B 0 DC 0 SIN(0 {AMP} {FRQ} 0 0 180)
* --- 移相タンク ---
CC   S4A QD  1p
LP   QD  LPX 2.21u
RLP  LPX 0  1.86
CP   QD  0  100p
RP   QD  0  4.7k
J17  VCC QD SF JF
RSF  SF  0  2.2k
* --- ギルバート ---
CUA  S4A UA1 1000p
RUA1 UA1 BU1 5.6k
RUA2 BU1 VBU 1k
CUB  S4B UB1 1000p
RUB1 UB1 BU2 5.6k
RUB2 BU2 VBU 1k
CQ   SF  QA1 1000p
RQ1  QA1 BL1 470
RQ2  BL1 VBL 10k
RQ3  BL2 VBL 10k
CG2  BL2 0   1000p
QL1  CL1 BL1 ET QX
QL2  CL2 BL2 ET QX
RTG  ET  0   390
QU1  OA BU1 CL1 QX
QU2  OB BU2 CL1 QX
QU3  OB BU1 CL2 QX
QU4  OA BU2 CL2 QX
RLA  VCC OA 1.5k
RLB  VCC OB 1.5k
CLA  OA 0 1000p
CLB  OB 0 1000p
RF1  OA LP 1k
CF1  LP 0 1000p
Q16  VCC LP AFE QX
RE16 AFE 0 4.7k
COUT AFE MPX 10u
RLD  MPX 0 10k
.end
