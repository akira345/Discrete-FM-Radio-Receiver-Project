* FM FRONT-END rev3 (reconstructed) - ngspice互換版（Rser を直列抵抗に展開）
.model JF3557 NJF(VTO=-0.7 BETA=25m CGS=7.1p CGD=2.9p IS=1e-14)
V1 5v 0 5
V2 N004 0 SIN(0 1m 80Meg)
RSRC N004 NANT 75
C1 N005 NANT 1000p
J1 N006 N007 N005 JF3557
R1 N005 0 100
R2 N007 0 100k
C2 N007 0 1000p
L1 N001 L1X 82n
RL1S L1X N006 0.9
C3A N006 TAP 33p
C3B TAP N001 39p
CVRF N006 NVR 24p
CB NVR 0 1000p
CSTR1 N006 N001 3p
C4 RFIN TAP 1000p
R6 RFIN 0 100k
L2 N009 L2X 56n
RL2S L2X 0 0.6
C5 N009 0 11p
CVLO N009 0 24p
CSTR2 N009 0 3p
C6 N009 N011 27p
C7 N011 0 27p
J2 N010 N009 N011 JF3557
R5 N011 0 2.2k
C16 N012 N011 1000p
R9 N012 0 100k
J4 N010 N012 N013 JF3557
R10 N013 0 470
C9 OSCOUT N013 1000p
J3 N003 RFIN OSCOUT JF3557
R7 OSCOUT 0 1k
L3 N003 L3X 4.7u
RL3S L3X N002 3
C8 N002 N003 47p
L4 0 L4X 0.65u
RL4S L4X IFOUT 1
R8 IFOUT 0 330
K1 L3 L4 0.71
CBULK 5VIN 0 10u
LBEAD 5VIN LBX 350n
RBEAD LBX 5v 0.045
RBPAR 5VIN 5v 330
C20 5v 0 0.1u
C21 5v 0 1000p
C10 N001 0 0.1u
C11 N001 0 1000p
RD1 N001 5v 0.01
C12 N002 0 0.1u
C13 N002 0 1000p
RD2 N002 5v 0.01
C14 N010 0 0.1u
C15 N010 0 1000p
RD3 N010 5v 0.01
.options gmin=1e-12 abstol=1e-13 reltol=1e-5 itl1=500
.control
op
print v(N005) v(N006) v(N007) v(N009) v(N011) v(N012) v(N013) v(RFIN) v(OSCOUT) v(N003) v(N002) v(N010) v(IFOUT)
print @j1[id] @j2[id] @j3[id] @j4[id]
print -i(v1)
.endc
.end
